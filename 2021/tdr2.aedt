# Ansys Electronics Desktop project, version 2021.1

design CircuitNetlist1 (Circuit Netlist)
options: Language=HSPICE IntegrationMethod=FFT
netlist:
.INCLUDE ./tdr.cir
reports:
  Transient Device Properties Table 2: O(a1:zl) vs Time on TRAN : TRAN [_selement_files_index=all]
